ADE simulation setup
Run mode: Single Run, Sweeps and Corners
Tests:
  DDIC_invertor_1: DDIC/invertor/schematic, simulator spectre
