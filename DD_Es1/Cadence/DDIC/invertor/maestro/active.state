ADE simulation setup
Test DDIC_invertor_1: DDIC/invertor/schematic, simulator spectre
  Models: /esat/micas-data/data/design/generic/045/gpdk045_v_4_0/gpdk045/../models/spectre/gpdk045.scs[mc]
  Temperature: 27
  Stimulus I: voltage pulse dc=0 val0=1 val1=0 period=5n delay=0 rise=100p fall=100p width=2.5n
  Stimulus VDD: voltage dc dc=1
  Stimulus VSS: voltage dc dc=0
  Analysis tran: stop=5n errpreset=conservative
  Signals: /ZN, /I, /PM0/S (terminal)
Run mode: Single Run, Sweeps and Corners
